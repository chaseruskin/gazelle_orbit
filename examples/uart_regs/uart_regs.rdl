// A minimal SystemRDL register block: a UART control/status pair.
// The addrmap name (`uart_regs`) is what PeakRDL uses to derive output
// filenames (uart_regs.sv, uart_regs_pkg.sv) and the top-level Verilog
// module name. Because orbit doesn't run PeakRDL, no HDL reference to
// this rule is visible in orbit's blueprint — consumers pin the dep by
// hand with `# keep` (see //dsp:dsp_top).
addrmap uart_regs {
    reg { field { sw=rw; hw=r; } enable; } ctrl;
    reg { field { sw=r;  hw=w; } status; } stat;
};
